# Ansys Electronics Desktop project, version 2025.2
materials:
  Melinex: permittivity=2.9 dielectric_loss_tangent=0.06
  air: permittivity=1.0006 permeability=1.0000004
  vacuum: permittivity=1

design MIMO (HFSS, HFSS Terminal Network, model units mm)
geometry:
  Substrate [Melinex] = box(corner=(0mm, 0mm, 0mm), size=(56mm, 56mm, 0.8mm))
  Msline = rectangle(corner=(-0.625mm, -15mm, 0.8mm), x_size=1.25mm, y_size=10.5mm)
  Patchc = circle(normal=Z, centre=(0mm, 0mm, 0.8mm), radius=5mm)
  patchr = rectangle(corner=(-5mm, 0mm, 0.8mm), x_size=10mm, y_size=10mm)
  Circle2 = circle(normal=Z, centre=(0mm, 0mm, 0.8mm), radius=4mm)
  Patchc.subtract(Circle2)
  Rectangle2 = rectangle(corner=(-4mm, 10mm, 0.8mm), x_size=8mm, y_size=-10mm)
  Patchc.subtract(Rectangle2)
  Rectangle3 = rectangle(corner=(-4mm, 10mm, 0.8mm), x_size=8mm, y_size=-10mm)
  patchr.subtract(Rectangle3)
  patchi = circle(normal=Z, centre=(0mm, 0mm, 0.8mm), radius=1.8mm)
  Joint = rectangle(corner=(-1mm, -1mm, 0.8mm), x_size=1mm, y_size=-3.6mm)
  Joint.rotate(axis=Z, angle=345deg)
  Msline.unite(Patchc, Joint, patchi, patchr)
  feed = rectangle(corner=(-0.625mm, -15mm, 0.8mm), z_size=-0.8mm, x_size=1.25mm)
  joint2 = rectangle(corner=(0mm, -1mm, 0.8mm), x_size=1mm, y_size=-3.6mm)
  joint2.rotate(axis=Z, angle=15deg)
  Msline.unite(joint2)
  Midstrip = rectangle(corner=(-0.5mm, 10mm, 0.8mm), x_size=1mm, y_size=-11mm)
  Msline.unite(Midstrip)
  Slot = rectangle(corner=(-10mm, 15mm, 0.8mm), x_size=20mm, y_size=-20.5mm)
  Slot.subtract(Msline)
  Rectangle7 = rectangle(corner=(-0.625mm, -5mm, 0.8mm), x_size=1.25mm, y_size=-10mm)
  Rectangle8 = rectangle(corner=(-1.2mm, -1.6mm, 0.8mm), x_size=2.6mm, y_size=-2.6mm)
  Slot.subtract(Rectangle8)
  Slot.unite(Rectangle7)
  [Slot, feed].move(10mm, 15mm, 0mm)
  Slot_1 = Slot.duplicate_around_axis(axis=Z, angle=90deg, total=2)
  feed_1 = feed.duplicate_around_axis(axis=Z, angle=90deg, total=2)
  [Slot_1, feed_1].move(56mm, 0mm, 0mm)
  Slot_1_1 = Slot_1.duplicate_around_axis(axis=Z, angle=90deg, total=2)
  feed_1_1 = feed_1.duplicate_around_axis(axis=Z, angle=90deg, total=2)
  [Slot_1_1, feed_1_1].move(56mm, 0mm, 0mm)
  feed_1_1_1 = feed_1_1.duplicate_around_axis(axis=Z, angle=90deg, total=2)
  Slot_1_1_1 = Slot_1_1.duplicate_around_axis(axis=Z, angle=90deg, total=2)
  [Slot_1_1_1, feed_1_1_1].move(56mm, 0mm, 0mm)
  Radbox [air] = box(corner=(-22mm, -22mm, -2.1mm), size=(100mm, 100mm, 5mm))
  Gnd1_1_1 [vacuum] = imported_body()
boundaries and excitations:
  PerfE1: Perfect E Objects=Slot
  PerfE2: Perfect E Objects=Slot_1
  PerfE3: Perfect E Objects=[Gnd1_1_1, Slot_1_1]
  PerfE4: Perfect E Objects=Slot_1_1_1
  Rad1: Radiation Objects=Radbox
  1: Lumped Port Objects=feed LumpedPortType=Modal Modes{Mode1{IntLine{(10, 0, 0) -> (10, 0, 0.8)} CharImp=Zpi}} Impedance=50ohm
  2: Lumped Port Objects=feed_1 LumpedPortType=Modal Modes{Mode1{IntLine{(56, 10, 0) -> (56, 10, 0.8)} CharImp=Zpi}} Impedance=50ohm
  3: Lumped Port Objects=feed_1_1 LumpedPortType=Modal Modes{Mode1{IntLine{(46, 56, 0) -> (46, 56, 0.8)} CharImp=Zpi}} Impedance=50ohm
  4: Lumped Port Objects=feed_1_1_1 LumpedPortType=Modal Modes{Mode1{IntLine{(0, 46, 0) -> (0, 46, 0.8)} CharImp=Zpi}} Impedance=50ohm
setups:
  Setup1: HfssDriven Frequency=16.5GHz MaxDeltaS=0.02 MaximumPasses=20 MinimumPasses=1 MinimumConvergedPasses=1 PercentRefinement=30 BasisOrder=1 PortAccuracy=2 DrivenSolverType="Direct Solver"
    sweep Sweep: 8.25GHz to 24.75GHz, 401 points; Type=Fast SaveFields
source amplitudes:
  1:1: 1V 0deg
  2:1, 3:1, 4:1: 0V 0deg
radiation setups:
  Infinite Sphere1: Infinite Sphere Theta=-180deg..180deg step 2deg Phi=0deg..360deg step 2deg
output variables:
  ECC12 = (mag(conjg(S(1,1))*S(1,2)+conjg(S(2,1))*S(2,2)))^2/((1-mag(S(1,1))^2-mag(S(2,1))^2)*(1-mag(S(2,2))^2-mag(S(1,2))^2))
  ECC13 = (mag(conjg(S(1,1))*S(1,3)+conjg(S(3,1))*S(3,3)))^2/((1-mag(S(1,1))^2-mag(S(3,1))^2)*(1-mag(S(3,3))^2-mag(S(1,3))^2))
  ECC14 = (mag(conjg(S(1,1))*S(1,4)+conjg(S(4,1))*S(4,4)))^2/((1-mag(S(1,1))^2-mag(S(4,1))^2)*(1-mag(S(4,4))^2-mag(S(1,4))^2))
  DG12 = 10*sqrt(1-ECC12^2)
  DG13 = 10*sqrt(1-ECC13^2)
  DG14 = 10*sqrt(1-ECC14^2)
  MEG12 = (1-(mag(S(1,1)))^2-(mag(S(1,2)))^2)/2
  MEG21 = (1-(mag(S(1,2)))^2-(mag(S(2,2)))^2)/2
  MEG13 = (1-(mag(S(1,1)))^2-(mag(S(1,3)))^2)/2
  MEG31 = (1-(mag(S(1,3)))^2-(mag(S(3,3)))^2)/2
  MEG14 = (1-(mag(S(1,1)))^2-(mag(S(1,4)))^2)/2
  MEG41 = (1-(mag(S(1,4)))^2-(mag(S(4,4)))^2)/2
  TARC12 = sqrt(((S(1,1)+S(1,2))^2+(S(2,1)+S(2,2))^2)/2)
  TARC13 = sqrt(((S(1,1)+S(1,3))^2+(S(3,1)+S(3,3))^2)/2)
  TARC14 = sqrt(((S(1,1)+S(1,4))^2+(S(4,1)+S(4,4))^2)/2)
  CCL12 = -ln((1 - (mag(S(1,1))^2 + mag(S(1,2))^2))*(1 - (mag(S(2,2))^2 + mag(S(2,1))^2)) - (conjg(S(2,2))*S(2,1) + conjg(S(1,2))*S(1,1))*(conjg(S(1,1))*S(1,2) + conjg(S(2,1))*S(2,2)))/ln(2)
  CCL13 = -ln((1 - (mag(S(1,1))^2 + mag(S(1,3))^2))*(1 - (mag(S(3,3))^2 + mag(S(3,1))^2)) - (conjg(S(3,3))*S(3,1) + conjg(S(1,3))*S(1,1))*(conjg(S(1,1))*S(1,3) + conjg(S(3,1))*S(3,3)))/ln(2)
  CCL14 = -ln((1 - (mag(S(1,1))^2 + mag(S(1,4))^2))*(1 - (mag(S(4,4))^2 + mag(S(4,1))^2)) - (conjg(S(4,4))*S(4,1) + conjg(S(1,4))*S(1,1))*(conjg(S(1,1))*S(1,4) + conjg(S(4,1))*S(4,4)))/ln(2)
  MEGratio12 = MEG12/MEG21
  MEGratio13 = MEG13/MEG31
  MEGratio14 = MEG14/MEG41
reports:
  Isolation: dB(S(1,1)), dB(S(2,2)), dB(S(3,3)), dB(S(4,4)) vs Freq on Setup1 : Sweep; markers m1 at 12.8205GHz, m2 at 19.25GHz, m3 at 15.4385GHz
  Transmission: dB(S(1,2)), dB(S(1,3)), dB(S(2,3)), dB(S(1,4)), dB(S(2,4)), dB(S(3,4)) vs Freq on Setup1 : Sweep
  ECC & DG: ECC12, ECC13, ECC14, DG12, DG13, DG14 vs Freq on Setup1 : Sweep
  MEG: dB20(MEG12), dB20(MEG21), dB20(MEG13), dB20(MEG31), dB20(MEG14), dB20(MEG41), dB20(MEGratio12), dB20(MEGratio13), dB20(MEGratio14) vs Freq on Setup1 : Sweep
  TARC: dB20(TARC12), dB20(TARC13), dB20(TARC14) vs Freq on Setup1 : Sweep
  CCL: mag(CCL12), mag(CCL13), mag(CCL14) vs Freq on Setup1 : Sweep
  Gain Plot1: dB(GainPhi), dB(GainTheta) vs Theta on Setup1 : Sweep, Infinite Sphere1 [Phi=0deg,90deg Freq=15.4GHz]
  Gain Plot2: dB(GainTotal) vs Phi, Theta on Setup1 : LastAdaptive, Infinite Sphere1 [Freq=15.4GHz]
  Directivity Plot1: dB(DirTotal) vs Phi, Theta on Setup1 : Sweep, Infinite Sphere1 [Freq=15.4GHz]
  S Parameter Plot1: dB(S(1,1)) vs Freq on Setup1 : Sweep; markers m1 at 12.859GHz, m2 at 19.1345GHz
  S Parameter Plot2: dB(S(1,2)) vs Freq on Setup1 : Sweep

design Single element (HFSS, HFSS Terminal Network, model units mm)
geometry:
  Substrate [Melinex] = box(corner=(-10mm, -15mm, 0mm), size=(20mm, 30mm, 0.8mm))
  Gnd1 = rectangle(corner=(10mm, -15mm, 0mm), x_size=-20mm, y_size=6mm)
  Gnd2 = rectangle(corner=(2mm, -9mm, 0mm), x_size=-4mm, y_size=18mm)
  Gnd1.unite(Gnd2)
  Msline = rectangle(corner=(-0.625mm, -15mm, 0.8mm), x_size=1.25mm, y_size=10.5mm)
  Patchc = circle(normal=Z, centre=(0mm, 0mm, 0.8mm), radius=5mm)
  patchr = rectangle(corner=(-5mm, 0mm, 0.8mm), x_size=10mm, y_size=10mm)
  Circle2 = circle(normal=Z, centre=(0mm, 0mm, 0.8mm), radius=4mm)
  Patchc.subtract(Circle2)
  Rectangle2 = rectangle(corner=(-4mm, 10mm, 0.8mm), x_size=8mm, y_size=-10mm)
  Patchc.subtract(Rectangle2)
  Rectangle3 = rectangle(corner=(-4mm, 10mm, 0.8mm), x_size=8mm, y_size=-10mm)
  patchr.subtract(Rectangle3)
  patchi = circle(normal=Z, centre=(0mm, 0mm, 0.8mm), radius=1.8mm)
  Joint = rectangle(corner=(-1mm, -1mm, 0.8mm), x_size=1mm, y_size=-3.6mm)
  Joint.rotate(axis=Z, angle=345deg)
  Msline.unite(Patchc, Joint, patchi, patchr)
  feed = rectangle(corner=(-0.625mm, -15mm, 0.8mm), z_size=-0.8mm, x_size=1.25mm)
  Rectangle4 = rectangle(corner=(-8mm, -13mm, 0mm), x_size=16mm, y_size=2mm)
  Rectangle5 = rectangle(corner=(-1mm, -13mm, 0mm), x_size=2mm, y_size=20mm)
  Rectangle5.unite(Rectangle4)
  Gnd1.subtract(Rectangle5)
  joint2 = rectangle(corner=(0mm, -1mm, 0.8mm), x_size=1mm, y_size=-3.6mm)
  joint2.rotate(axis=Z, angle=15deg)
  Msline.unite(joint2)
  Midstrip = rectangle(corner=(-0.5mm, 10mm, 0.8mm), x_size=1mm, y_size=-11mm)
  Msline.unite(Midstrip)
  Radiationbox [air] = box(corner=(-20mm, -25mm, -10mm), size=(40mm, 50mm, 20mm))
  Slot = rectangle(corner=(-10mm, 15mm, 0.8mm), x_size=20mm, y_size=-20.5mm)
  Slot.subtract(Msline)
  Rectangle7 = rectangle(corner=(-0.625mm, -5mm, 0.8mm), x_size=1.25mm, y_size=-10mm)
  Rectangle8 = rectangle(corner=(-1.2mm, -1.6mm, 0.8mm), x_size=2.6mm, y_size=-2.6mm)
  Slot.subtract(Rectangle8)
  Slot.unite(Rectangle7)
boundaries and excitations:
  Rad1: Radiation Objects=Radiationbox
  PerfE1: Perfect E Objects=[Gnd1, Slot]
  1: Lumped Port Objects=feed LumpedPortType=Modal Modes{Mode1{IntLine{(0.05, -15, 0) -> (0, -15, 0.8)} CharImp=Zpi}} Impedance=50ohm
setups:
  Setup1: HfssDriven Frequency=16.5GHz MaxDeltaS=0.02 MaximumPasses=20 MinimumPasses=1 MinimumConvergedPasses=1 PercentRefinement=30 BasisOrder=1 PortAccuracy=2 DrivenSolverType="Direct Solver"
    sweep Sweep: 8.25GHz to 24.75GHz, 401 points; Type=Fast SaveFields
source amplitudes:
  1:1: 1V 0deg
radiation setups:
  Infinite Sphere1: Infinite Sphere Theta=0deg..180deg step 10deg Phi=0deg..360deg step 10deg
reports:
  S Parameter Plot1: dB(S(1,1)) vs Freq on Setup1 : Sweep; markers m1 at 13.86GHz, m2 at 18.315GHz, m3 at 16.45875GHz
